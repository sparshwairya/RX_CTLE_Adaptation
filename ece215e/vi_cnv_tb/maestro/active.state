ADE simulation setup
Test ece215e_vi_cnv_tb_1: ece215e/vi_cnv_tb/schematic, simulator spectre
  Models: /w/apps4/public_libraries/tech/cadence/cadence/45nm/gpdk045_v_3_5/gpdk045/../models/spectre/gpdk045.scs[tt]
  Variables: I = 250u; w = 2u; Tb = 100p; VCC = 1.1; Vin_low = 650m
  Temperature: 27
  Analysis tran: stop=1u errpreset=conservative
  Output IT("/I0/Vctrl") (unticked)
  Output average(clip(IT("/I0/Vctrl") 2e-07 2e-06)) (unticked)
  Output average(clip((VT("/net1") - VT("/net2")) 2e-07 1e-06))
  Output average(clip(VT("/Vctrl") 2e-07 1e-06))
  Output average(clip(IT("/C0/PLUS") 2e-07 1e-06))
  Signals: /net1, /net2, /Vctrl, /I0/Vctrl (terminal), /C0/PLUS (terminal)
Run mode: Single Run, Sweeps and Corners
Setup values for test ece215e_vi_cnv_tb_1: Tb = 100p 125p 83.33p; VCC = 1.1 1.05; Vin_low = 0.88 0.83
