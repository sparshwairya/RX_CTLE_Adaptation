ADE simulation setup
Test ece215e_vi_cnv_tb_1: ece215e/vi_cnv_tb/schematic, simulator spectre
  Models: /w/apps4/public_libraries/tech/cadence/cadence/45nm/gpdk045_v_3_5/gpdk045/../models/spectre/gpdk045.scs[tt]
  Variables: Tb = 55.556p 45.45n 62.5n; VCC = 1.05; Vin_low = 0.83
  Temperature: 27
  Analysis dc: (saves the operating point)
  Analysis tran: stop=1000n
  Output IT("/I0/Vctrl") (unticked)
  Output average(clip(IT("/I0/Vctrl") 2e-07 1e-06)) (unticked)
  Output ((VT("/net1")**2) - (VT("/net2")**2)) (unticked)
  Output average(clip(VT("/Vctrl") 2e-07 1e-06))
  Signals: /net1, /net2, /Vctrl, /VDD, /VIN1, /VIN2, /I0/Vctrl (terminal)
Run mode: Single Run, Sweeps and Corners
Setup values for test ece215e_vi_cnv_tb_1: Tb = 100p 125p 83.33p; VCC = 1.1 1.05; Vin_low = 0.88 0.83
