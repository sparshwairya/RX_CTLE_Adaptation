ADE simulation setup
Run mode: Single Run, Sweeps and Corners
Tests:
  ece215e_vi_cnv_tb_1: ece215e/vi_cnv_tb/schematic, simulator spectre
    Variables: Tb = 55.556p 45.45n 62.5n; VCC = 1.1 1.05; Vin_low = 0.88 0.83
    Outputs: ((VT("/net1")**2) - (VT("/net2")**2))
