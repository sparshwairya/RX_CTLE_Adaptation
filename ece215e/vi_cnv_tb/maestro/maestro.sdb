ADE simulation setup
Run mode: Single Run, Sweeps and Corners
Tests:
  ece215e_vi_cnv_tb_1: ece215e/vi_cnv_tb/schematic, simulator spectre
    Outputs: ((VT("/net1")**2) - (VT("/net2")**2))
