ADE simulation setup
Run mode: Single Run, Sweeps and Corners
Tests:
  215E_sim_tb_ctle_final_standalone_1: ece215e/tb_final_toplevel/schematic, simulator spectre
    Variables: bitper = 111.1p; Vdd = 1.1; res = 8K:500:10K
    Outputs: average(clip((VT("/net1") - VT("/net2")) 1.2e-07 1e-06)); average(clip((VT("/VOUT1")) 1.2e-07 1e-06)); average(clip((VT("/Vtune")) 1.2e-07 1e-06)); average(clip(VT("/Vtune") 1.2e-07 1e-06))
