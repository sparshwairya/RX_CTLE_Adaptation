ADE simulation setup
Test 215E_sim_tb_ctle_final_standalone_1: ece215e/tb_final_toplevel/schematic, simulator spectre
  Models: /w/apps4/public_libraries/tech/cadence/cadence/45nm/gpdk045_v_3_5/gpdk045/../models/spectre/gpdk045.scs[tt]
  Variables: res = 8K; bitper = 111.1p; Vdd = 1.1
  Temperature: 27
  Analysis tran: stop=1u errpreset=conservative
  Output average(clip((VT("/net1") - VT("/net2")) 1.2e-07 1e-06))
  Output average(clip(VT("/Vtune") 1.2e-07 1e-06))
  Signals: /Vtune, /VSS, /net2, /net1, /VOP_CTLE, /VON_CTLE
Run mode: Single Run, Sweeps and Corners
Setup values for test 215E_sim_tb_ctle_final_standalone_1: res = 8K:500:10K
