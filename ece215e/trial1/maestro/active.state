ADE simulation setup
Test ece215e_trial1_1: ece215e/trial1/schematic, simulator spectre
  Models: /w/apps4/public_libraries/tech/cadence/cadence/45nm/gpdk045_v_3_5/gpdk045/../models/spectre/gpdk045.scs[mc]
  Variables: Iin = 500u
  Temperature: 27
  Analysis dc: (saves the operating point)
Run mode: Single Run, Sweeps and Corners
