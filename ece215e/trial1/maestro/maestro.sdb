ADE simulation setup
Run mode: Single Run, Sweeps and Corners
Tests:
  ece215e_trial1_1: ece215e/trial1/schematic, simulator spectre
    Variables: Iin = 500u
