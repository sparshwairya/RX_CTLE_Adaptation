ADE simulation setup
Run mode: Single Run, Sweeps and Corners
Tests:
  ece215e_pd_tb_1: ece215e/pd_tb/schematic, simulator spectre
    Variables: tb = 90.9p 100p 111.1p 125p 142.8p; VCC = 1.1; Vin_l = 650m
    Outputs: psd((VT("/VIN1")) 1e-07 1e-06 512 ?windowName "Hanning" ?smooth 1 ?windowSize 256 ?detrending "None" ?cohGain 1); average(clip((VT("/VOUT1") - VT("/VOUT2")) 1e-07 2e-06)); average(clip((VT("/VOUT1") - VT("/VOUT2")) 1e-07 1e-06)); average(clip((VT("/VOUT1") - VT("/VOUT2")) 1.2e-07 1e-06))
Corners (nominal off):
  model folders: /w/apps4/public_libraries/tech/cadence/cadence/45nm/gpdk045_v_3_5/gpdk045/../models/spectre
  C0 (off): temperature=-40; VCC=1; Vin_l=0.78; gpdk045.scs[ss]
  C1: gpdk045.scs[tt]
