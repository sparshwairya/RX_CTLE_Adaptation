ADE simulation setup
Run mode: Single Run, Sweeps and Corners
Tests:
  ece215e_pd_tb_1: ece215e/pd_tb/schematic, simulator spectre
    Variables: res = 2.842K 3.1578K 3.55K; tb = 50p 55.556p 62.5p
    Outputs: average(clip((VT("/VOUT1") + VT("/VOUT2")) 1e-07 1e-06)); psd((VT("/VIN1")) 1e-07 1e-06 512 ?windowName "Hanning" ?smooth 1 ?windowSize 256 ?detrending "None" ?cohGain 1)
