ADE simulation setup
Run mode: Single Run, Sweeps and Corners
Tests:
  ece215e_pd_tb_1: ece215e/pd_tb/schematic, simulator spectre
    Variables: tb = 83.33p 90.91p 100p 111.11p 125p; VCC = 1.1; Vin_l = 0.88; I = 250u
    Outputs: average(clip((VT("/VOUT1") + VT("/VOUT2")) 1e-07 1e-06)); psd((VT("/VIN1")) 1e-07 1e-06 512 ?windowName "Hanning" ?smooth 1 ?windowSize 256 ?detrending "None" ?cohGain 1)
