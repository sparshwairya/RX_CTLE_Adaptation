ADE simulation setup
Test ece215e_pd_tb_1: ece215e/pd_tb/schematic, simulator spectre
  Models: /w/apps4/public_libraries/tech/cadence/cadence/45nm/gpdk045_v_3_5/gpdk045/../models/spectre/gpdk045.scs[tt]
  Temperature: 27
  Analysis tran: stop=1u errpreset=conservative
  Output (VT("/VOUT1") - VT("/VOUT2"))
  Output (VT("/VIN1") - VT("/VIN2"))
  Output average(clip((VT("/VOUT1") - VT("/VOUT2")) 1e-07 1e-06))
  Output average(clip((VT("/VOUT1") + VT("/VOUT2")) 1e-07 1e-06)) (unticked)
  Signals: /VDD, /VIN2, /VIN1, /VOUT2, /VOUT1, /I0/net5, /I0/net2, /I0/net6, /I0/net7, /I0/net25, /I0/R2/MINUS (terminal), /I0/R1/MINUS (terminal)
Run mode: Single Run, Sweeps and Corners
Setup values for test ece215e_pd_tb_1: tb = 50p 55.556p 62.5p; VCC = 1.1 1.05 1.2; Vin_l = 0.88 0.83 0.98
