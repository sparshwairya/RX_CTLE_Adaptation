ADE simulation setup
Run mode: Single Run, Sweeps and Corners
Tests:
  ece215e_vi_cnv_tb_1: ece215e/vi_cnv_tb_dc/schematic, simulator spectre
    Variables: VCC = 1.1; Tb = 1; Vin = 0 1m; Vin_low = 1
    Outputs: ((VT("/net1")**2) - (VT("/net2")**2)); average(clip(VT("/Vctrl") 2e-07 5e-06)); average(clip(VT("/Vctrl") 5e-07 5e-06)); average(clip(VT("/Vctrl") 5e-07 2e-06)); average(clip(IT("/C0/PLUS") 5e-07 2e-06)); average(clip(IT("/net1") 2e-07 1e-06)); average(clip((VT("/VOUT1") - VT("/VOUT2")) 1e-07 1e-06)); average(clip((VT("/net1") - VT("/net2")) 1e-07 1e-06)); average(clip((VT("/net1") - VT("/net2")) 5e-07 2e-06))
Global variables:
  Vin_low = 0.88 0.83
  VCC = 1.1 1.05
  Tb = 100p 125p 83.33p
