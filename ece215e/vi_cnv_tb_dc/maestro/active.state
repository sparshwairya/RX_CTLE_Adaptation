ADE simulation setup
Test ece215e_vi_cnv_tb_1: ece215e/vi_cnv_tb_dc/schematic, simulator spectre
  Models: /w/apps4/public_libraries/tech/cadence/cadence/45nm/gpdk045_v_3_5/gpdk045/../models/spectre/gpdk045.scs[tt]
  Variables: Tb = 1; Vin = 0; Vin_low = 1; VCC = 1.1
  Temperature: 27
  Analysis dc: sweep Vin start=0 stop=300m step=3m (saves the operating point)
  Output IT("/I0/Vctrl") (unticked)
  Output average(clip(IT("/I0/Vctrl") 2e-07 1e-06)) (unticked)
  Output average(clip((VT("/net1") - VT("/net2")) 5e-07 2e-06))
  Output average(clip(VT("/Vctrl") 5e-07 2e-06))
  Output average(clip(IT("/C0/PLUS") 5e-07 2e-06))
  Signals: /net2, /Vctrl, /I0/Vctrl (terminal), /net6, /I0/net3, /I0/net9, /I0/net6, /I0/net4, /I0/PM3/D (terminal), /I0/PM0/D (terminal), /V15/PLUS (terminal)
Run mode: Single Run, Sweeps and Corners
Global variables:
  Vin_low = 0.88 0.83
  VCC = 1.1 1.05
  Tb = 100p 125p 83.33p
Setup values for test ece215e_vi_cnv_tb_1: Vin = 0 1m
