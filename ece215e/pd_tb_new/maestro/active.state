ADE simulation setup
Test ece215e_pd_tb_1: ece215e/pd_tb_new/schematic, simulator spectre
  Models: /w/apps4/public_libraries/tech/cadence/cadence/45nm/gpdk045_v_3_5/gpdk045/../models/spectre/gpdk045.scs[tt]
  Variables: I = {From/To}LinearStepCount:100u:5:300u{From/To}; VCC = 1.1; Vin_l = 0.88; tb = 100p
  Temperature: 27
  Analysis tran: stop=1u errpreset=conservative
  Output (VT("/VOUT1") - VT("/VOUT2"))
  Output (VT("/VIN1") - VT("/VIN2"))
  Output average(clip((VT("/VOUT1") - VT("/VOUT2")) 1e-07 1e-06))
  Output average(clip((VT("/VOUT1") + VT("/VOUT2")) 1e-07 1e-06)) (unticked)
  Signals: /VIN2, /VIN1, /VOUT2, /VOUT1
Run mode: Single Run, Sweeps and Corners
Setup values for test ece215e_pd_tb_1: tb = 100p 125p
