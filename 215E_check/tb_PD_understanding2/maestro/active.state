ADE simulation setup
Test 215E_check_tb_PD_understanding2_1: 215E_check/tb_PD_understanding2/schematic, simulator spectre
  Models: /w/apps4/public_libraries/tech/cadence/cadence/45nm/gpdk045_v_3_5/gpdk045/../models/spectre/gpdk045.scs[mc]
  Variables: vid = 0
  Temperature: 27
  Analysis dc: sweep vid start=0 stop=0.2 lin=50 (saves the operating point)
