ADE simulation setup
Test 215E_check_channel_chara_1: 215E_check/channel_chara/schematic, simulator spectre
  Models: /w/apps4/public_libraries/tech/cadence/cadence/45nm/gpdk045_v_3_5/gpdk045/../models/spectre/gpdk045.scs[tt]
  Temperature: 27
  Analysis dc: (saves the operating point)
  Analysis tran: stop=200n errpreset=conservative outputstart=160n
  Output avg_vod = average((vtime('tran "/Vlp") - vtime('tran "/Vln")))
  Signals: /R19/MINUS (terminal), /R20/MINUS (terminal), /Iprbs1/PLUS (terminal), /Iprbs2/PLUS (terminal)
