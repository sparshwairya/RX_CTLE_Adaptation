ADE simulation setup
Test 215E_check_tb_ctle_first_cut_1: 215E_check/tb_ctle_first_cut/schematic, simulator spectre
  Models: /w/apps4/public_libraries/tech/cadence/cadence/45nm/gpdk045_v_3_5/gpdk045/../models/spectre/gpdk045.scs[tt]
  Variables: bitper = 100p
  Temperature: 27
  Analysis dc: (saves the operating point)
  Analysis ac: start=10M stop=100G dec=50
