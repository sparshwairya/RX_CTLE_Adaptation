ADE simulation setup
Test 215E_check_capchara_1: 215E_check/capchara/schematic, simulator spectre
  Models: /w/apps4/public_libraries/tech/cadence/cadence/45nm/gpdk045_v_3_5/gpdk045/../models/spectre/gpdk045.scs[ss]
  Variables: vcap = 0.7
  Temperature: -40
  Analysis dc: (saves the operating point)
  Analysis ac: start=10M stop=100M dec=50
  Output capNMOS = (abs(value(ifreq('ac "/V1/PLUS") 50000000)) / (6.28 * 50000000))
  Output capPMOS = (abs(value(ifreq('ac "/V2/PLUS") 50000000)) / (6.28 * 50000000))
  Output nmos1v_cgg = pv("NCAP1v.mcore" "cgg" ?result "dcOpInfo")
  Output pmos2v_cgg = pv("PCAP2v.mcore" "cgg" ?result "dcOpInfo")
  Output nmos2v_cgg = pv("NCAP2v.mcore" "cgg" ?result "dcOpInfo")
  Output pmos1v_cgg = pv("PCAP1v.mcore" "cgg" ?result "dcOpInfo")
  Signals: /NCAP1v/G (terminal), /PCAP2v/G (terminal), /V2/MINUS (terminal), /V1/PLUS (terminal)
