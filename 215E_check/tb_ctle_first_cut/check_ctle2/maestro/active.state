ADE simulation setup
Test 215E_check_check_ctle2_1: 215E_check/check_ctle2/schematic, simulator spectre
  Models: /w/apps4/public_libraries/tech/cadence/cadence/45nm/gpdk045_v_3_5/gpdk045/../models/spectre/gpdk045.scs[tt]
  Temperature: 27
  Analysis dc: (saves the operating point)
  Analysis tran: stop=100n errpreset=conservative
Run mode: Single Run, Sweeps and Corners
