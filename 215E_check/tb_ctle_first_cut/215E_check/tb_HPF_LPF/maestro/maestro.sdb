ADE simulation setup
Run mode: Single Run, Sweeps and Corners
Tests:
  215E_check_tb_HPF_LPF_1: 215E_check/tb_HPF_LPF/schematic, simulator spectre
    Variables: bitper = 10p
