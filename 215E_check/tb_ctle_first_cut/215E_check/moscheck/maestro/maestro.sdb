ADE simulation setup
Run mode: Single Run, Sweeps and Corners
Tests:
  215E_check_moscheck_1: 215E_check/moscheck/schematic, simulator spectre
