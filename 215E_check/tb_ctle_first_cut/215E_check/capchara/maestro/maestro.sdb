ADE simulation setup
Run mode: Single Run, Sweeps and Corners
Tests:
  215E_check_capchara_1: 215E_check/capchara/schematic, simulator spectre
    Variables: vcap = 0.7
    Outputs: /NCAP1v/G; /PCAP2v/G; /V2/MINUS; /V1/PLUS; nmos2v_cgg; pmos1v_cgg
Corners (nominal off):
  tt_27_1v (off): temperature=27; vcap=-0.4:0.020:1.1
  ss_n40_1v (off): temperature=-40; vcap=-0.4:0.020:1.1
  tt_27_2v (off): temperature=27; vcap=-0.4:0.020:1.8
  ss_n40_2v: temperature=-40; vcap=-0.4:0.020:1.8
