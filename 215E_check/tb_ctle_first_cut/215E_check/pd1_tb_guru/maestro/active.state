ADE simulation setup
Test 215E_check_pd1_tb_guru_1: 215E_check/pd1_tb_guru/schematic, simulator spectre
  Models: /w/apps4/public_libraries/tech/cadence/cadence/45nm/gpdk045_v_3_5/gpdk045/../models/spectre/gpdk045.scs[mc]
  Temperature: 27
  Analysis dc: (saves the operating point)
