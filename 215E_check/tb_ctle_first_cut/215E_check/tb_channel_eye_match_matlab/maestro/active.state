ADE simulation setup
Test 215E_check_tb_channel_eye_match_matlab_1: 215E_check/tb_channel_eye_match_matlab/schematic, simulator spectre
  Models: /w/apps4/public_libraries/tech/cadence/cadence/45nm/gpdk045_v_3_5/gpdk045/../models/spectre/gpdk045.scs[tt]
  Variables: bitper = 200p
  Temperature: 27
  Analysis tran: stop=200n errpreset=conservative maxstep=1p
Run mode: Single Run, Sweeps and Corners
