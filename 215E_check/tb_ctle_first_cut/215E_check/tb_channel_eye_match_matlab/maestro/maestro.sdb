ADE simulation setup
Run mode: Single Run, Sweeps and Corners
Tests:
  215E_check_tb_channel_eye_match_matlab_1: 215E_check/tb_channel_eye_match_matlab/schematic, simulator spectre
    Variables: bitper = 200p
