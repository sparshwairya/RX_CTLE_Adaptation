ADE simulation setup
Run mode: Single Run, Sweeps and Corners
Tests:
  215E_check_tb_curbias_1: 215E_check/tb_curbias/schematic, simulator spectre
