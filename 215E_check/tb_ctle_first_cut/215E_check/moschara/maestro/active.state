ADE simulation setup
Test 215E_check_moschara_1: 215E_check/moschara/schematic, simulator spectre
  Models: /w/apps4/public_libraries/tech/cadence/cadence/45nm/gpdk045_v_3_5/gpdk045/../models/spectre/gpdk045.scs[mc]
  Variables: idmir = 100u; vds = 200m
  Temperature: 27
  Operating points saved: /MDUT (ids vgs vds vth vdsat gm gds cgg cgs cgd cgb cdd cds cdb id ron gmoverid self_gain rout ft region)
  Analysis dc: (saves the operating point)
  Output ids_DUT = pv("MDUT" "ids" ?result "dcOpInfo")
  Output vgs_DUT = abs(pv("MDUT" "vgs" ?result "dcOpInfo"))
  Output vds_DUT = abs(pv("MDUT" "vds" ?result "dcOpInfo"))
  Output vdsat_DUT = abs(pv("MDUT" "vdsat" ?result "dcOpInfo"))
  Output vth_DUT = abs(pv("MDUT" "vth" ?result "dcOpInfo"))
  Output gm_DUT = abs(pv("MDUT" "gm" ?result "dcOpInfo"))
  Output gds_DUT = abs(pv("MDUT" "gds" ?result "dcOpInfo"))
  Output cgg_DUT = abs(pv("MDUT" "cgg" ?result "dcOpInfo"))
  Output cgs_DUT = abs(pv("MDUT" "cgs" ?result "dcOpInfo"))
  Output cgd_DUT = abs(pv("MDUT" "cgd" ?result "dcOpInfo"))
  Output cgb_DUT = abs(pv("MDUT" "cgb" ?result "dcOpInfo"))
  Output cdd_DUT = abs(pv("MDUT" "cdd" ?result "dcOpInfo"))
  Output cds_DUT = abs(pv("MDUT" "cds" ?result "dcOpInfo"))
  Output cdb_DUT = abs(pv("MDUT" "cdb" ?result "dcOpInfo"))
  Output id_DUT = abs(pv("MDUT" "id" ?result "dcOpInfo"))
  Output ron_DUT = abs(pv("MDUT" "ron" ?result "dcOpInfo"))
  Output gmoverid_DUT = abs(pv("MDUT" "gmoverid" ?result "dcOpInfo"))
  Output self_gain_DUT = abs(pv("MDUT" "self_gain" ?result "dcOpInfo"))
  Output rout_DUT = pv("MDUT" "rout" ?result "dcOpInfo")
  Output pv("MDUT" "ft" ?result "dcOpInfo") (unticked)
  Output region_DUT = pv("MDUT" "region" ?result "dcOpInfo")
  Output fT_CALC_DUT = (gm_DUT / (6.28 * cgg_DUT))
  Output Vth_delta = (pv("MDUT" "vth" ?result "dcOpInfo") - pv("MMIR" "vth" ?result "dcOpInfo"))
Run mode: Monte Carlo Sampling
Corners (nominal off):
  tt (off): temperature=27; idmir=20u:100u:1000u; vds=0.1:0.1:1.1
  tt_less_cur (off): temperature=27; idmir=10u:50u:500u; vds=0.1:0.1:1.1
  ss (off): temperature=-40; idmir=20u:100u:1000u; vds=0.1:0.1:1.1
  ss_less_cur (off): temperature=-40; idmir=10u:50u:500u; vds=0.1:0.1:1.1
  nom: temperature=27; idmir=250u; vds=0.5
Monte Carlo Sampling options: mismatchvary=Gaussian, sssnumpoints=7000, mismatchscale=1.0, processscale=1.0, pointsPerJobPolicy=Group automatically, maxPointsPerJob=10, reliabilitymode=singlestress, wcdinitialpoints=200, mcnumpoints=200, yeyistostart=3.0, mcSigmaTarget=3, yeiterations=10, processvary=Gaussian, yeexpectedyield=3, mcmethod=mismatch, yeusehistorymc=0, yeuseautomcsamples=1, yecreatecorners=0, mcdistandscalingmismatchenable=0, parasiticanalysis=0, mcFilterPluginEnabled=0, haveyeyieldtostart=1, yeusevarreduction=1, mcdistandscalingprocessenable=0
