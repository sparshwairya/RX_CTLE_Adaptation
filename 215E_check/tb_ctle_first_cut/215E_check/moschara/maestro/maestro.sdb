ADE simulation setup
Run mode: Monte Carlo Sampling
Tests:
  215E_check_moschara_1: 215E_check/moschara/schematic, simulator spectre
    Variables: idmir = 100u; vds = 200m
    Outputs: ids_DUT; pv("MDUT" "vth" ?result "dcOpInfo"); pv("MDUT" "vdsat" ?result "dcOpInfo"); pv("MDUT" "vgs" ?result "dcOpInfo"); pv("MDUT" "vds" ?result "dcOpInfo"); pv("MDUT" "gds" ?result "dcOpInfo"); pv("MDUT" "cgg" ?result "dcOpInfo"); pv("MDUT" "cgs" ?result "dcOpInfo"); pv("MDUT" "cgd" ?result "dcOpInfo"); pv("MDUT" "cgb" ?result "dcOpInfo"); pv("MDUT" "cdd" ?result "dcOpInfo"); pv("MDUT" "cds" ?result "dcOpInfo"); pv("MDUT" "cdb" ?result "dcOpInfo"); pv("MDUT" "id" ?result "dcOpInfo"); pv("MDUT" "ron" ?result "dcOpInfo"); pv("MDUT" "gmoverid" ?result "dcOpInfo"); pv("MDUT" "self_gain" ?result "dcOpInfo"); rout_DUT; pv("MDUT" "ft" ?result "dcOpInfo"); region_DUT; (pv("MDUT" "gm" ?result "dcOpInfo") / ((pv("MDUT" "gm" ?result "dcOpInfo") + pv("MDUT" "gm" ?result "dcOpInfo")) / 6.28)); fT_CALC_DUT; vgs_DUT; vds_DUT; vdsat_DUT; vth_DUT; gm_DUT; gds_DUT; cgg_DUT; cgs_DUT; cgd_DUT; cgb_DUT; cdd_DUT; cds_DUT; cdb_DUT; id_DUT; ron_DUT; gmoverid_DUT; self_gain_DUT
Corners (nominal off):
  tt (off): temperature=27; idmir=20u:100u:1000u; vds=0.1:0.1:1.1
  tt_less_cur (off): temperature=27; idmir=10u:50u:500u; vds=0.1:0.1:1.1
  ss (off): temperature=-40; idmir=20u:100u:1000u; vds=0.1:0.1:1.1
  ss_less_cur (off): temperature=-40; idmir=10u:50u:500u; vds=0.1:0.1:1.1
  nom: temperature=27; idmir=250u; vds=0.5
Monte Carlo Sampling options: mismatchvary=Gaussian, sssnumpoints=7000, mismatchscale=1.0, processscale=1.0, pointsPerJobPolicy=Group automatically, maxPointsPerJob=10, reliabilitymode=singlestress, wcdinitialpoints=200, mcnumpoints=200, yeyistostart=3.0, mcSigmaTarget=3, yeiterations=10, processvary=Gaussian, yeexpectedyield=3, mcmethod=mismatch, yeusehistorymc=0, yeuseautomcsamples=1, yecreatecorners=0, mcdistandscalingmismatchenable=0, parasiticanalysis=0, mcFilterPluginEnabled=0, haveyeyieldtostart=1, yeusevarreduction=1, mcdistandscalingprocessenable=0
