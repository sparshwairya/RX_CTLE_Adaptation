ADE simulation setup
Run mode: Single Run, Sweeps and Corners
Tests:
  215E_check_mosreschara_1: 215E_check/mosreschara/schematic, simulator spectre
    Variables: vds = 0.02; vgs = 0.4
Corners (nominal off):
  nom: temperature=27; vgs=0.05:0.02:0.8; vds=0.02
