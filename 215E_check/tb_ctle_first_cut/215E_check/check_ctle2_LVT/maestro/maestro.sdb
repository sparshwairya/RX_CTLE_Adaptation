ADE simulation setup
Run mode: Single Run, Sweeps and Corners
Tests:
  215E_check_check_ctle2_1: 215E_check/check_ctle2_LVT/schematic, simulator spectre
