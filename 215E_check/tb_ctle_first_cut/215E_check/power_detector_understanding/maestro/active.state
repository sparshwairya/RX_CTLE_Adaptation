ADE simulation setup
Test 215E_check_power_detector_understanding_1: 215E_check/power_detector_understanding/schematic, simulator spectre
  Models: /w/apps4/public_libraries/tech/cadence/cadence/45nm/gpdk045_v_3_5/gpdk045/../models/spectre/gpdk045.scs[tt]
  Temperature: 27
  Analysis tran: stop=100n errpreset=conservative
  Analysis dc: (saves the operating point)
  Output average(((vtime('tran "/VoHP") - vtime('tran "/VoHM"))**2))
  Output average(((vtime('tran "/VoLP") - vtime('tran "/VoLM"))**2))
  Signals: /V3/PLUS (terminal)
