ADE simulation setup
Test 215E_check_hw2_1_check_1: 215E_check/hw2_1_check/schematic, simulator spectre
  Models: /w/apps4/public_libraries/tech/cadence/cadence/45nm/gpdk045_v_3_5/gpdk045/../models/spectre/gpdk045.scs[tt]
  Temperature: 27
  Analysis tran: stop=10n errpreset=conservative
Run mode: Single Run, Sweeps and Corners
