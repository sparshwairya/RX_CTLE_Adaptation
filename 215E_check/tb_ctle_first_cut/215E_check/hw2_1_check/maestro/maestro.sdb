ADE simulation setup
Run mode: Single Run, Sweeps and Corners
Tests:
  215E_check_hw2_1_check_1: 215E_check/hw2_1_check/schematic, simulator spectre
