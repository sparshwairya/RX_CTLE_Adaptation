ADE simulation setup
Test 215E_check_check_ctle_1: 215E_check/check_ctle/schematic, simulator spectre
  Models: /w/apps4/public_libraries/tech/cadence/cadence/45nm/gpdk045_v_3_5/gpdk045/../models/spectre/gpdk045.scs[tt]
  Temperature: 27
  Analysis dc: (saves the operating point)
  Analysis ac: start=10M stop=1T dec=20
Run mode: Single Run, Sweeps and Corners
