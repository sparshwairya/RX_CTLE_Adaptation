ADE simulation setup
Test 215E_check_moscheck2_1: 215E_check/moscheck2/schematic, simulator spectre
  Models: /w/apps4/public_libraries/tech/cadence/cadence/45nm/gpdk045_v_3_5/gpdk045/../models/spectre/gpdk045.scs[mc]
  Temperature: 27
  Analysis tran: stop=1 errpreset=conservative
  Analysis dc: (saves the operating point)
Run mode: Single Run, Sweeps and Corners
