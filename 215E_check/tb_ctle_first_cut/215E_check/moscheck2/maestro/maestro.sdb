ADE simulation setup
Run mode: Single Run, Sweeps and Corners
Tests:
  215E_check_moscheck2_1: 215E_check/moscheck2/schematic, simulator spectre
