ADE simulation setup
Run mode: Single Run, Sweeps and Corners
Tests:
  215E_check_tb_PD_understanding2_1: 215E_check/tb_PD_understanding2/schematic, simulator spectre
    Variables: vid = 0
