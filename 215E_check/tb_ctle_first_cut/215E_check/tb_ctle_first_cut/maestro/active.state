ADE simulation setup
Test 215E_check_tb_ctle_first_cut_1: 215E_check/tb_ctle_first_cut/schematic, simulator spectre
  Models: /w/apps4/public_libraries/tech/cadence/cadence/45nm/gpdk045_v_3_5/gpdk045/../models/spectre/gpdk045.scs[tt]
  Variables: bitper = 100p
  Temperature: 27
  Analysis tran: stop=400n errpreset=conservative
  Output db20(((vfreq('ac "/Vop2") - vfreq('ac "/Von2")) / (vfreq('ac "/Vlp") - vfreq('ac "/Vln")))) (unticked)
  Output db20(((vfreq('ac "/Vlp") - vfreq('ac "/Vln")) / (vfreq('ac "/Vsp") - vfreq('ac "/Vsn")))) (unticked)
  Output db20(((vfreq('ac "/Vop2") - vfreq('ac "/Von2")) / (vfreq('ac "/Vsp") - vfreq('ac "/Vsn")))) (unticked)
Run mode: Single Run, Sweeps and Corners
