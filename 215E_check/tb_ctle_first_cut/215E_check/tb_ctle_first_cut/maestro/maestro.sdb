ADE simulation setup
Run mode: Single Run, Sweeps and Corners
Tests:
  215E_check_tb_ctle_first_cut_1: 215E_check/tb_ctle_first_cut/schematic, simulator spectre
    Variables: bitper = 100p
