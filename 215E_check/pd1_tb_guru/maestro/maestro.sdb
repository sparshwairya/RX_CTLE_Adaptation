ADE simulation setup
Run mode: Single Run, Sweeps and Corners
Tests:
  215E_check_pd1_tb_guru_1: 215E_check/pd1_tb_guru/schematic, simulator spectre
