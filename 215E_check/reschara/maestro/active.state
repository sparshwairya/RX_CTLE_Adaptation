ADE simulation setup
Test 215E_check_reschara_1: 215E_check/reschara/schematic, simulator spectre
  Models: /w/apps4/public_libraries/tech/cadence/cadence/45nm/gpdk045_v_3_5/gpdk045/../models/spectre/gpdk045.scs[mc]
  Temperature: 27
  Analysis dc: (saves the operating point)
  Output RSTI1 = abs((0.2 / pv("V0" "i" ?result "dcOpInfo")))
  Output ROXIDE1 = abs((0.2 / pv("V1" "i" ?result "dcOpInfo")))
  Output RSTI2 = abs((0.2 / pv("V2" "i" ?result "dcOpInfo")))
  Output ROXIDE2 = abs((0.2 / pv("V3" "i" ?result "dcOpInfo")))
  Output RSTI1-RSTI2 = (RSTI1 - RSTI2)
  Output ROXIDE1-ROXIDE2 = (ROXIDE1 - ROXIDE2)
  Output RSTI_percent_change = (((RSTI1 - RSTI2) * 100) / RSTI1)
  Output ROXIDE_percent_change = (((ROXIDE1 - ROXIDE2) * 100) / ROXIDE1)
  Signals: /V0/PLUS (terminal), /V1/PLUS (terminal)
Run mode: Monte Carlo Sampling
Corners (nominal off):
  nom: temperature=27
Monte Carlo Sampling options: mismatchvary=Gaussian, sssnumpoints=7000, mismatchscale=1.0, processscale=1.0, pointsPerJobPolicy=Group automatically, maxPointsPerJob=10, reliabilitymode=singlestress, wcdinitialpoints=200, mcnumpoints=200, yeyistostart=3.0, mcSigmaTarget=3, yeiterations=10, processvary=Gaussian, yeexpectedyield=3, mcmethod=mismatch, yeusehistorymc=0, yeuseautomcsamples=1, yecreatecorners=0, mcdistandscalingmismatchenable=0, parasiticanalysis=0, mcFilterPluginEnabled=0, haveyeyieldtostart=1, yeusevarreduction=1, mcdistandscalingprocessenable=0
