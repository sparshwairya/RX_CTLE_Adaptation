ADE simulation setup
Run mode: Monte Carlo Sampling
Tests:
  215E_check_reschara_1: 215E_check/reschara/schematic, simulator spectre
    Outputs: /RSTI/PLUS; /ROXIDE/PLUS; /V0/PLUS; /V1/PLUS; ROXIDE1; RSTI2; abs((0.2 / pv("V1" "i" ?result "dcOpInfo"))); ROXIDE2; RSTI1-RSTI2; ROXIDE1-ROXIDE2; RSTI_percent_change; ROXIDE_percent_change
Corners (nominal off):
  nom: temperature=27
Monte Carlo Sampling options: mismatchvary=Gaussian, sssnumpoints=7000, mismatchscale=1.0, processscale=1.0, pointsPerJobPolicy=Group automatically, maxPointsPerJob=10, reliabilitymode=singlestress, wcdinitialpoints=200, mcnumpoints=200, yeyistostart=3.0, mcSigmaTarget=3, yeiterations=10, processvary=Gaussian, yeexpectedyield=3, mcmethod=mismatch, yeusehistorymc=0, yeuseautomcsamples=1, yecreatecorners=0, mcdistandscalingmismatchenable=0, parasiticanalysis=0, mcFilterPluginEnabled=0, haveyeyieldtostart=1, yeusevarreduction=1, mcdistandscalingprocessenable=0
