ADE simulation setup
Test 215E_check_mosreschara_1: 215E_check/mosreschara/schematic, simulator spectre
  Models: /w/apps4/public_libraries/tech/cadence/cadence/45nm/gpdk045_v_3_5/gpdk045/../models/spectre/gpdk045.scs[tt]
  Variables: vds = 0.02; vgs = 0.4
  Temperature: 27
  Analysis dc: (saves the operating point)
  Output ron = pv("NM0" "ron" ?result "dcOpInfo")
Run mode: Single Run, Sweeps and Corners
Corners (nominal off):
  nom: temperature=27; vgs=0.05:0.02:0.8; vds=0.02
