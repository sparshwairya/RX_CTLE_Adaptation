ADE simulation setup
Run mode: Single Run, Sweeps and Corners
Tests:
  215E_check_channel_chara_1: 215E_check/channel_chara/schematic, simulator spectre
