ADE simulation setup
Test 215E_check_channel_sparam_chara_1: 215E_check/channel_sparam_chara/schematic, simulator spectre
  Models: /w/apps4/public_libraries/tech/cadence/cadence/45nm/gpdk045_v_3_5/gpdk045/../models/spectre/gpdk045.scs[mc]
  Temperature: 27
  Analysis sp: start=100M stop=20G dec=100
