ADE simulation setup
Test 215E_check_pd_tb_guru_HPF_LPF_1: 215E_check/pd_tb_guru_HPF_LPF/schematic, simulator spectre
  Models: /w/apps4/public_libraries/tech/cadence/cadence/45nm/gpdk045_v_3_5/gpdk045/../models/spectre/gpdk045.scs[tt]
  Variables: bitper = 111p; tb = 111p; VCC = 1.1; Vin_l = 0.65
  Temperature: 27
  Analysis tran: stop=1u errpreset=conservative
  Output average(clip((vtime('tran "/VOUT2") - vtime('tran "/VOUT1")) 3e-06 5.5e-06))
Run mode: Single Run, Sweeps and Corners
