ADE simulation setup
Run mode: Single Run, Sweeps and Corners
Tests:
  215E_check_pd_tb_guru_HPF_LPF_1: 215E_check/pd_tb_guru_HPF_LPF/schematic, simulator spectre
    Variables: bitper = 111p; tb = 111p; VCC = 1.1; Vin_l = 0.65
