ADE simulation setup
Test ece215e_pd_tb_1: ece215e/pd_tb/schematic, simulator spectre
  Models: /w/apps4/public_libraries/tech/cadence/cadence/45nm/gpdk045_v_3_5/gpdk045/../models/spectre/gpdk045.scs[tt]
  Variables: VCC = 1.1 1.05 1.2; Vin_l = 0.88 0.83 0.98; tb = 100p 125p 83.33p
  Temperature: 27
  Analysis tran: stop=1u errpreset=conservative
  Output (VT("/VOUT1") - VT("/VOUT2"))
  Output (VT("/VIN1") - VT("/VIN2"))
  Output average(clip((VT("/VOUT1") - VT("/VOUT2")) 1e-07 1e-06))
  Output average(clip((VT("/VOUT1") + VT("/VOUT2")) 1e-07 1e-06)) (unticked)
  Output VT("/I0/a")
  Output VT("/I0/b")
  Output VT("/I0/c")
  Output VT("/I0/d")
  Output ((VT("/I0/a") + VT("/I0/b")) / 2)
  Output ((VT("/I0/c") + VT("/I0/d")) / 2)
  Output IT("/I0/R1/MINUS")
  Output IT("/I0/R2/MINUS")
  Signals: /VOUT2, /VOUT1, /I0/R2/MINUS (terminal), /I0/R1/MINUS (terminal), /I0/c, /I0/a, /I0/b, /I0/d
Run mode: Single Run, Sweeps and Corners
