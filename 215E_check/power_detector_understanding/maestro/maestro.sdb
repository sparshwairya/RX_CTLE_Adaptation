ADE simulation setup
Run mode: Single Run, Sweeps and Corners
Tests:
  215E_check_power_detector_understanding_1: 215E_check/power_detector_understanding/schematic, simulator spectre
