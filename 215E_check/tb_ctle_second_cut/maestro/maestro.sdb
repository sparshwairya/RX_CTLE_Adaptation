ADE simulation setup
Run mode: Single Run, Sweeps and Corners
Tests:
  215E_check_tb_ctle_first_cut_1: 215E_check/tb_ctle_second_cut/schematic, simulator spectre
    Variables: bitper = 111p; vctrl = 0.555; Vdd = 1.1
    Outputs: HP; LP; HP - LP; HP CM; LP CM
Corners:
  nom (off): temperature=27; vctrl=0.1:0.025:0.9
