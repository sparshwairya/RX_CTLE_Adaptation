ADE simulation setup
Test 215E_check_tb_ctle_first_cut_1: 215E_check/tb_ctle_second_cut/schematic, simulator spectre
  Models: /w/apps4/public_libraries/tech/cadence/cadence/45nm/gpdk045_v_3_5/gpdk045/../models/spectre/gpdk045.scs[tt]
  Variables: Vdd = 1.1; vctrl = 0.555; bitper = 111p
  Temperature: 27
  Initial conditions: /net5 = 1.1; /Vctrl = 1.1
  Analysis tran: stop=1u errpreset=conservative maxstep=10p
  Output db20(((vfreq('ac "/Vop2") - vfreq('ac "/Von2")) / (vfreq('ac "/Vlp") - vfreq('ac "/Vln")))) (unticked)
  Output db20(((vfreq('ac "/Vlp") - vfreq('ac "/Vln")) / (vfreq('ac "/Vsp") - vfreq('ac "/Vsn")))) (unticked)
  Output db20(((vfreq('ac "/Vop2") - vfreq('ac "/Von2")) / (vfreq('ac "/Vsp") - vfreq('ac "/Vsn")))) (unticked)
  Output (IT("/I2/NM0/D") + IT("/I2/NM1/D")) (unticked)
  Output (IT("/I2/NM4/D") + IT("/I2/NM5/D")) (unticked)
  Output IT("/I2/R1/PLUS") (unticked)
  Output IT("/I2/R2/PLUS") (unticked)
  Output IT("/I2/C4/PLUS") (unticked)
  Output HP = (abs((abs(vtime('tran "/I2/a")) - abs(vtime('tran "/I2/b")))) + 0.877) (unticked)
  Output LP = (abs((abs(vtime('tran "/I2/c")) - abs(vtime('tran "/I2/d")))) + 0.877) (unticked)
  Output HP - LP = (abs((abs(vtime('tran "/I2/a")) - abs(vtime('tran "/I2/b")))) - abs((abs(vtime('tran "/I2/c")) - abs(vtime('tran "/I2/d"))))) (unticked)
  Output deriv_HPF_current = deriv((IT("/I2/NM0/D") + IT("/I2/NM1/D"))) (unticked)
  Output HP CM = ((abs((abs(vtime('tran "/I2/a")) + abs(vtime('tran "/I2/b")))) * 0.5) + 0.877) (unticked)
  Output LP CM = ((abs((abs(vtime('tran "/I2/c")) + abs(vtime('tran "/I2/d")))) * 0.5) + 0.877) (unticked)
  Output average(clip(vtime('tran "/Vctrl") 5e-07 1e-06))
  Signals: /I2/NM0/D (terminal), /I2/NM1/D (terminal), /I2/NM4/D (terminal), /I2/NM5/D (terminal)
Run mode: Single Run, Sweeps and Corners
Corners:
  nom (off): temperature=27; vctrl=0.1:0.025:0.9
