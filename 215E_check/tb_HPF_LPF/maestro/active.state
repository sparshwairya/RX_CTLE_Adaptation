ADE simulation setup
Test 215E_check_tb_HPF_LPF_1: 215E_check/tb_HPF_LPF/schematic, simulator spectre
  Models: /w/apps4/public_libraries/tech/cadence/cadence/45nm/gpdk045_v_3_5/gpdk045/../models/spectre/gpdk045.scs[mc]
  Variables: bitper = 10p
  Temperature: 27
  Analysis tran: stop=100n
  Output ((vtime('tran "/a") + vtime('tran "/b")) * 0.5)
  Output ((vtime('tran "/c") + vtime('tran "/d")) * 0.5)
