ADE simulation setup
Test 215E_check_tb_curbias_1: 215E_check/tb_curbias/schematic, simulator spectre
  Models: /w/apps4/public_libraries/tech/cadence/cadence/45nm/gpdk045_v_3_5/gpdk045/../models/spectre/gpdk045.scs[tt]
  Temperature: 27
  Analysis ac: start=10 stop=100 dec=10
  Analysis dc: (saves the operating point)
  Output (0.18 / value(ifreq('ac "/V3/PLUS") 10))
  Signals: /V3/PLUS (terminal)
