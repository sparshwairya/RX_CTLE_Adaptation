ADE simulation setup
Test 215E_sim_tb_ctle_final_standalone_1: 215E_sim/tb_final_toplevel/schematic, simulator spectre
  Models: /w/apps4/public_libraries/tech/cadence/cadence/45nm/gpdk045_v_3_5/gpdk045/../models/spectre/gpdk045.scs[tt]
  Variables: bitper = 111p; Vdd = 1.1
  Temperature: 27
  Initial conditions: /Vtune = 1.1
  Analysis tran: stop=2u errpreset=conservative maxstep=10p
Run mode: Single Run, Sweeps and Corners
