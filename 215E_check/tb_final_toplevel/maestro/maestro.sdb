ADE simulation setup
Run mode: Single Run, Sweeps and Corners
Tests:
  215E_sim_tb_ctle_final_standalone_1: 215E_sim/tb_final_toplevel/schematic, simulator spectre
    Variables: bitper = 111p; Vdd = 1.1
